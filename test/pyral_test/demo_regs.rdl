// Register model for the PyRAL test, written in the classic .rdl syntax
// that peakrdl's importer accepts.
addrmap demo_regs {
    name = "DemoRegs";
    desc = "Register block used by the PyRAL test";
    default regwidth = 32;

    reg {
        name = "ctrl";
        desc = "Control register";
        field { sw = rw; hw = r; reset = 0; } ctrl_enable[0:0];
        field { sw = rw; hw = r; reset = 0; } ctrl_mode[7:4];
    } ctrl @ 0x0;

    reg {
        name = "status";
        desc = "Status register, read-only in software";
        field { sw = r; hw = w; } status_state[3:0];
        field { sw = r; hw = w; } status_busy[4:4];
    } status @ 0x4;

    reg {
        name = "scratch";
        desc = "Plain read/write data register";
        field { sw = rw; hw = r; reset = 0; } scratch_data[31:0];
    } scratch @ 0x8;
};
